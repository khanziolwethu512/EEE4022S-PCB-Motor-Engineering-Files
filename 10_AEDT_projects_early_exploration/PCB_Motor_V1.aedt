# Ansys Electronics Desktop project, version 2025.2
materials:
  steel_1010: permittivity=1 permeability{HUnit=A_per_meter BUnit=tesla curve (0, 0) (238.7, 0.2003) (318.3, 0.3204) (358.1, 0.40045) (437.7, 0.50055) (477.5, 0.5606) (636.6, 0.7908) (795.8, 0.931) (1114.1, 1.1014) (1273.2, 1.2016) (1591.5, 1.302) (2228.2, 1.4028) (3183.1, 1.524) (4774.6, 1.626) (6366.2, 1.698) (7957.7, 1.73) (15915.5, 1.87) (31831, 1.99) (47746.5, 2.04) (63662, 2.07) (79577.5, 2.095) (159155, 2.2) (318310, 2.4)} conductivity=2000000 lande_g_factor=2 mass_density=7872
  copper: permeability=0.999991 conductivity=58000000 mass_density=8933
  NdFe35: permittivity=1 permeability=1.0997785 conductivity=625000 magnetic_coercivity{Magnitude=-890000A_per_meter DirComp1=1 DirComp2=0 DirComp3=0} lande_g_factor=2 mass_density=7400
  vacuum: permittivity=1
  steel_1010_3DAF0.950: CoordinateSystemType=Cylindrical permeability{HUnit=A_per_meter BUnit=tesla curve (0, 0) (238.7, 0.2003) (318.3, 0.3204) (358.1, 0.40045) (437.7, 0.50055) (477.5, 0.5606) (636.6, 0.7908) (795.8, 0.931) (1114.1, 1.1014) (1273.2, 1.2016) (1591.5, 1.302) (2228.2, 1.4028) (3183.1, 1.524) (4774.6, 1.626) (6366.2, 1.698) (7957.7, 1.73) (15915.5, 1.87) (31831, 1.99) (47746.5, 2.04) (63662, 2.07) (79577.5, 2.095) (159155, 2.2) (318310, 2.4) (1909860, 4.4)} conductivity=2000000 mass_density=7872 stacking_type=Lamination stacking_factor=0.95 stacking_direction=V(1)
  NdFe35_3DSF1.000_N: CoordinateSystemType=Cylindrical permeability=1.0997785 conductivity=625000 magnetic_coercivity{Magnitude=-890000A_per_meter DirComp1=0 DirComp2=0 DirComp3=1} mass_density=7400
  NdFe35_3DSF1.000_S: CoordinateSystemType=Cylindrical permeability=1.0997785 conductivity=625000 magnetic_coercivity{Magnitude=-890000A_per_meter DirComp1=0 DirComp2=0 DirComp3=-1} mass_density=7400
  copper_75C: conductivity=58000000

design RMxprtDesign1 (RMxprt, Generic Rotating Machines, model units mm)
machine:
  Machine: RotorType=15 StatorType=12 SourceType=1 Structure=2 ImportRotor=0 ImportStator=0 StatorCenter=0 RotorCenter=0 ImportType MasterSlaveOnXais Fraction=0 AirGapLength=0.5mm DoubleSided=0
  Stator: NumberOfPoles=12 NumberOfSlots=15 SlotType=3 CircuitType=0
  Shaft: FrictionLoss=12W WindLoss=12W ReferenceSpeed=3000rpm
  Rotor: NumberOfPoles=12
  Stator Core: OuterDiameter=120mm InnerDiameter=70mm Length=25mm SteelType=steel_1010 StackingFactor=0.95
  Stator Winding: WindingType=Half-Coiled WindingLayers=2 ParallelBranches=1 ConductorsPerSlot=48 CoilPitch=1 EndAdjustment=0mm BaseInnerRadius=0mm TipInnerDiameter=0mm EndClearance=0mm CoilWrap=0mm SlotLiner=0mm WedgeThickness=0mm LayerInsulation=0mm BottomInsulation=0mm LimitedFillFactor=0.75 WdgNumberofPriodicMultipler=1 WdgConstantPitch WdgConstantTurns Wdgcoil_turns(24, 24, 24, 24, 24, 24, 24, 24, 24, 24, 24, 24, 24, 24, 24) Wdgcoil_name(A, A, A, -C, -C, B, B, B, -A, -A, C, C, C, -B, -B) Wdgcoil_go(1T, 2T, 3T, 4T, 5T, 6T, 7T, 8T, 9T, 10T, 11T, 12T, 13T, 14T, 15T) Wdgcoil_re(2B, 3B, 4B, 5B, 6B, 7B, 8B, 9B, 10B, 11B, 12B, 13B, 14B, 15B, 1B) NumberOfStrands=1 WireWrap=0mm InterturnInsulation=0mm WireDiameter=0mm WireWidth=0mm WireThickness=0mm Gauge=AUTO CorrectionFactor=1 TopSpareSpace=0 BottomSpareSpace=0 ConductorType=copper
  Rotor Core: OuterDiameter=120mm InnerDiameter=70mm Length=15mm SteelType=steel_1010 StackingFactor=0.95 SkewWidth=0deg
  Stator Circuit: TriggerPulseWidth=120deg TransistorDrop=0.7V DiodeDrop=0.7V ControlType=0 ModulationIndex=0 CarrierFrequencyTimes=0 LeadAngleOfTrigger=0deg MaximumCurrent=0A MinimumCurrent=0A ReferenceAmplitude=0A HysteresisBand=0A
  Core Slot: Hs0=1.5mm Hs1=2mm Hs2=13mm Bs0=3mm Bs1=8mm Bs2=8mm Rs=0.4mm ToothWidth=0mm
  Core Pole: Embrace=0.9 MagnetThickness=8mm MagnetLength=25mm MagnetType=NdFe35
setups:
  Setup1: GRM Motor RatedOutputPower=2500W RatedVoltage=220V RatedSpeed=3900rpm OperatingTemperature=75cel LoadType=ConstPower RatedPowerFactor=0.8 Frequency=60Hz
reports:
  Current Plot1: InputCurrent, Efficiency, OutputPower, OutputTorque vs Ang on Setup1 : Performance

design MaxCir1 (Maxwell Circuit)
variables:
  Kle = 1
  Kang = 1 + 1205.23*Kle
components:
  Winding_14 = Winding(Name=PhaseA)
  Winding_21 = Winding(Name=PhaseB)
  Winding_28 = Winding(Name=PhaseC)
  Res_35 = Res(Name=A R=0.15926846ohm)
  Res_42 = Res(Name=B R=0.15926846ohm)
  Res_49 = Res(Name=C R=0.15926846ohm)
  Ind_56 = Ind(Name=A L=4.8645381e-05H*Kle)
  Ind_63 = Ind(Name=B L=4.8645381e-05H*Kle)
  Ind_70 = Ind(Name=C L=4.8645381e-05H*Kle)
  Ammeter_77 = Ammeter(Name=IA)
  Ammeter_84 = Ammeter(Name=IB)
  Ammeter_91 = Ammeter(Name=IC)
  VPulse_98 = VPulse(V1=-1 Tr=0 Tf=0 Td=0.00010401577 Pw=0.00085470085 Period=0.0025641026)
  VPulse_105 = VPulse(V1=-1 Tr=0 Tf=0 Td=0.00053136619 Pw=0.00085470085 Period=0.0025641026)
  VPulse_112 = VPulse(V1=-1 Tr=0 Tf=0 Td=0.00095871662 Pw=0.00085470085 Period=0.0025641026)
  VPulse_119 = VPulse(V1=-1 Tr=0 Tf=0 Td=0.001386067 Pw=0.00085470085 Period=0.0025641026)
  VPulse_126 = VPulse(V1=-1 Tr=0 Tf=0 Td=0.0018134175 Pw=0.00085470085 Period=0.0025641026)
  VPulse_133 = VPulse(V1=-1 Tr=0 Tf=0 Td=0.0022407679 Pw=0.00085470085 Period=0.0025641026)
  Res_140 = Res()
  Res_147 = Res()
  Res_154 = Res()
  Res_161 = Res()
  Res_168 = Res()
  Res_175 = Res()
  VoltmeterG_182 = VoltmeterG(Name=Vc1)
  VoltmeterG_189 = VoltmeterG(Name=Vc2)
  VoltmeterG_196 = VoltmeterG(Name=Vc3)
  VoltmeterG_203 = VoltmeterG(Name=Vc4)
  VoltmeterG_210 = VoltmeterG(Name=Vc5)
  VoltmeterG_217 = VoltmeterG(Name=Vc6)
  VDC_224 = VDC(V=110V)
  VDC_231 = VDC(V=110V)
  DIODE_238 = DIODE(MOD=DModel1)
  DIODE_245 = DIODE(MOD=DModel1)
  DIODE_252 = DIODE(MOD=DModel1)
  DIODE_259 = DIODE(MOD=DModel1)
  DIODE_266 = DIODE(MOD=DModel1)
  DIODE_273 = DIODE(MOD=DModel1)
  DIODE_280 = DIODE(MOD=DModel1)
  DIODE_287 = DIODE(MOD=DModel1)
  DIODE_294 = DIODE(MOD=DModel1)
  DIODE_301 = DIODE(MOD=DModel1)
  DIODE_308 = DIODE(MOD=DModel1)
  DIODE_315 = DIODE(MOD=DModel1)
  SW_V_322 = SW_V(ID_V=IVc1 MOD=SModel1)
  SW_V_329 = SW_V(ID_V=IVc4 MOD=SModel1)
  SW_V_336 = SW_V(ID_V=IVc3 MOD=SModel1)
  SW_V_343 = SW_V(ID_V=IVc6 MOD=SModel1)
  SW_V_350 = SW_V(ID_V=IVc5 MOD=SModel1)
  SW_V_357 = SW_V(ID_V=IVc2 MOD=SModel1)
  DIODE_Model_364 = DIODE_Model(RS=0ohm DeviceName=DModel1)
  SW_VModel_371 = SW_VModel(Von=0V Voff=0V DeviceName=SModel1)
nets:
  0: VPulse_119.1, VPulse_112.1, VPulse_98.1, VPulse_105.1, VPulse_126.1, VDC_231.0, VDC_224.1, VPulse_133.1
  net_1: Winding_14.1, Winding_21.1, Winding_28.1
  net_10: Ind_56.0, Ammeter_77.1
  net_11: Ammeter_84.1, Ind_63.0
  net_12: Ammeter_91.1, Ind_70.0
  net_19: VPulse_98.0, VoltmeterG_182.0, Res_140.0
  net_20: VPulse_105.0, VoltmeterG_189.0, Res_147.0
  net_21: VPulse_112.0, VoltmeterG_196.0, Res_154.0
  net_22: VPulse_119.0, VoltmeterG_203.0, Res_161.0
  net_23: VPulse_126.0, Res_168.0, VoltmeterG_210.0
  net_24: Res_175.0, VoltmeterG_217.0, VPulse_133.0
  net_25: Res_175.1, Res_161.1, Res_154.1, Res_168.1, Res_140.1, Res_147.1
  net_31: VDC_224.0, DIODE_259.1, DIODE_245.1, DIODE_308.0, DIODE_294.0, DIODE_280.0, DIODE_273.1
  net_33: DIODE_315.1, VDC_231.1, DIODE_238.0, DIODE_252.0, DIODE_266.0, DIODE_301.1, DIODE_287.1
  net_34: SW_V_329.0, SW_V_322.1, Ammeter_77.0, DIODE_238.1, DIODE_245.0
  net_35: Ammeter_84.0, SW_V_336.1, SW_V_343.0, DIODE_259.0, DIODE_252.1
  net_36: Ammeter_91.0, SW_V_350.1, SW_V_357.0, DIODE_266.1, DIODE_273.0
  net_37: SW_V_329.1, DIODE_287.0
  net_38: SW_V_343.1, DIODE_301.0
  net_39: DIODE_315.0, SW_V_357.1
  net_4: Res_35.1, Winding_14.0
  net_40: SW_V_322.0, DIODE_280.1
  net_42: SW_V_336.0, DIODE_294.1
  net_44: SW_V_350.0, DIODE_308.1
  net_5: Res_42.1, Winding_21.0
  net_6: Res_49.1, Winding_28.0
  net_7: Ind_56.1, Res_35.0
  net_8: Ind_63.1, Res_42.0
  net_9: Res_49.0, Ind_70.1

design Maxwell3DDesign1 (Maxwell 3D, Transient, model units mm)
options: ComputeTransientInductance
variables:
  fractions = 1
  halfAxial = 0
  endRegion = 13.116212mm
geometry:
  Band [vacuum] = user_primitive(RMxprt/Band, DiaGap=95mm, DiaYoke=159.73945mm, Length=23.25mm, SegAngle=0deg, Fractions=1, HalfAxial=0, InfoCore=100)
  Band.move(0mm, 0mm, -11.625mm)
  InnerRegion [vacuum] = user_primitive(RMxprt/Band, DiaGap=95mm, DiaYoke=159.73945mm, Length=23mm, SegAngle=0deg, Fractions=1, HalfAxial=0, InfoCore=100)
  InnerRegion.move(0mm, 0mm, -11.75mm)
  StatorRegion [vacuum] = user_primitive(RMxprt/Band, DiaGap=95mm, DiaYoke=159.73945mm, Length=25mm, SegAngle=0deg, Fractions=1, HalfAxial=0, InfoCore=100)
  StatorRegion.move(0mm, 0mm, 12.75mm)
  OuterRegion [vacuum] = user_primitive(RMxprt/Band, DiaGap=95mm, DiaYoke=159.73945mm, Length=48.5mm, SegAngle=0deg, Fractions=fractions, HalfAxial=halfAxial, InfoCore=100)
  OuterRegion.move(0mm, 0mm, 1mm)
  Tool = user_primitive(RMxprt/Band, DiaGap=95mm, DiaYoke=159.73945mm, Length=48.5mm, SegAngle=0deg, Fractions=fractions, HalfAxial=halfAxial, InfoCore=1)
  Tool.move(0mm, 0mm, 1mm)
  Stator [steel_1010_3DAF0.950] = user_primitive(RMxprt/DiskSlotCore, DiaOuter=120mm, DiaInner=70mm, Thickness=25mm, Gap=0.25mm, Skew=0deg, Slots=15, SlotType=3, Hs0=1.5mm, Hs01=0mm, Hs1=2mm, Hs2=13mm, Bs0=3mm, Bs1=8mm, Bs2=8mm, Rs=0.4mm, FilletType=0, HalfSlot=0, RingLength=0mm, RingHeight=0mm, SegAngle=30deg, InfoCore=0)
  Coil_0 [copper_75C] = user_primitive(RMxprt/DiskCoil, DiaOuter=120mm, DiaInner=70mm, Thickness=25mm, Gap=0.25mm, Skew=0deg, Slots=15, SlotType=3, Hs0=1.5mm, Hs1=2mm, Hs2=13mm, Bs0=3mm, Bs1=8mm, Bs2=8mm, Rs=0.4mm, FilletType=0, Layers=2, CoilPitch=1, EndExt=0mm, EndClr=0.8mm, SegAngle=10deg, InfoCoil=1)
  Coil_1..Coil_14 [copper_75C] = Coil_0.duplicate_around_axis(axis=Z, angle=24deg, total=15)
  CoilTerm_0 [copper_75C] = user_primitive(RMxprt/DiskCoil, DiaOuter=120mm, DiaInner=70mm, Thickness=25mm, Gap=0.25mm, Skew=0deg, Slots=15, SlotType=3, Hs0=1.5mm, Hs1=2mm, Hs2=13mm, Bs0=3mm, Bs1=8mm, Bs2=8mm, Rs=0.4mm, FilletType=0, Layers=2, CoilPitch=1, EndExt=0mm, EndClr=0.8mm, SegAngle=10deg, InfoCoil=2)
  CoilTerm_1..CoilTerm_14 [copper_75C] = CoilTerm_0.duplicate_around_axis(axis=Z, angle=24deg, total=15)
  Rotor [steel_1010_3DAF0.950] = user_primitive(RMxprt/DiskPMCore, DiaOuter=120mm, DiaInner=70mm, Thickness=15mm, Gap=-0.25mm, Skew=0deg, Poles=12, Embrace=0.9, ThickMag=8mm, InfoCore=0)
  Mag_0 [NdFe35_3DSF1.000_N] = user_primitive(RMxprt/DiskPMCore, DiaOuter=120mm, DiaInner=70mm, Thickness=15mm, Gap=-0.25mm, Skew=0deg, Poles=12, Embrace=0.9, ThickMag=8mm, InfoCore=2)
  Mag_1 [NdFe35_3DSF1.000_S], Mag_2 [NdFe35_3DSF1.000_N], Mag_3 [NdFe35_3DSF1.000_S], Mag_4 [NdFe35_3DSF1.000_N], Mag_5 [NdFe35_3DSF1.000_S], Mag_6 [NdFe35_3DSF1.000_N], Mag_7 [NdFe35_3DSF1.000_S], Mag_8 [NdFe35_3DSF1.000_N], Mag_9 [NdFe35_3DSF1.000_S], Mag_10 [NdFe35_3DSF1.000_N], Mag_11 [NdFe35_3DSF1.000_S] = Mag_0.duplicate_around_axis(axis=Z, angle=30deg, total=12)
  Tool_1 = Tool.copy()
  Band.subtract(Tool_1)
  Tool_2 = Tool.copy()
  InnerRegion.subtract(Tool_2)
  Tool_3 = Tool.copy()
  StatorRegion.subtract(Tool_3)
  Tool_4 = Tool.copy()
  Stator.subtract(Tool_4)
  Tool_5 = Tool.copy()
  Coil_0.subtract(Tool_5)
  Tool_6 = Tool.copy()
  Coil_1.subtract(Tool_6)
  Tool_7 = Tool.copy()
  Coil_2.subtract(Tool_7)
  Tool_8 = Tool.copy()
  Coil_3.subtract(Tool_8)
  Tool_9 = Tool.copy()
  Coil_4.subtract(Tool_9)
  Tool_10 = Tool.copy()
  Coil_5.subtract(Tool_10)
  Tool_11 = Tool.copy()
  Coil_6.subtract(Tool_11)
  Tool_12 = Tool.copy()
  Coil_7.subtract(Tool_12)
  Tool_13 = Tool.copy()
  Coil_8.subtract(Tool_13)
  Tool_14 = Tool.copy()
  Coil_9.subtract(Tool_14)
  Tool_15 = Tool.copy()
  Coil_10.subtract(Tool_15)
  Tool_16 = Tool.copy()
  Coil_11.subtract(Tool_16)
  Tool_17 = Tool.copy()
  Coil_12.subtract(Tool_17)
  Tool_18 = Tool.copy()
  Coil_13.subtract(Tool_18)
  Tool_19 = Tool.copy()
  Coil_14.subtract(Tool_19)
  Tool_20 = Tool.copy()
  CoilTerm_0.subtract(Tool_20)
  Tool_21 = Tool.copy()
  CoilTerm_1.subtract(Tool_21)
  Tool_22 = Tool.copy()
  CoilTerm_2.subtract(Tool_22)
  Tool_23 = Tool.copy()
  CoilTerm_3.subtract(Tool_23)
  Tool_24 = Tool.copy()
  CoilTerm_4.subtract(Tool_24)
  Tool_25 = Tool.copy()
  CoilTerm_5.subtract(Tool_25)
  Tool_26 = Tool.copy()
  CoilTerm_6.subtract(Tool_26)
  Tool_27 = Tool.copy()
  CoilTerm_7.subtract(Tool_27)
  Tool_28 = Tool.copy()
  CoilTerm_8.subtract(Tool_28)
  Tool_29 = Tool.copy()
  CoilTerm_9.subtract(Tool_29)
  Tool_30 = Tool.copy()
  CoilTerm_10.subtract(Tool_30)
  Tool_31 = Tool.copy()
  CoilTerm_11.subtract(Tool_31)
  Tool_32 = Tool.copy()
  CoilTerm_12.subtract(Tool_32)
  Tool_33 = Tool.copy()
  CoilTerm_13.subtract(Tool_33)
  Tool_34 = Tool.copy()
  CoilTerm_14.subtract(Tool_34)
  Tool_35 = Tool.copy()
  Rotor.subtract(Tool_35)
  Tool_36 = Tool.copy()
  Mag_0.subtract(Tool_36)
  Tool_37 = Tool.copy()
  Mag_1.subtract(Tool_37)
  Tool_38 = Tool.copy()
  Mag_2.subtract(Tool_38)
  Tool_39 = Tool.copy()
  Mag_3.subtract(Tool_39)
  Tool_40 = Tool.copy()
  Mag_4.subtract(Tool_40)
  Tool_41 = Tool.copy()
  Mag_5.subtract(Tool_41)
  Tool_42 = Tool.copy()
  Mag_6.subtract(Tool_42)
  Tool_43 = Tool.copy()
  Mag_7.subtract(Tool_43)
  Tool_44 = Tool.copy()
  Mag_8.subtract(Tool_44)
  Tool_45 = Tool.copy()
  Mag_9.subtract(Tool_45)
  Tool_46 = Tool.copy()
  Mag_10.subtract(Tool_46)
  Mag_11.subtract(Tool)
motion:
  MotionSetup1: Band Move_Type=Rotate Coordinate_System=Global Axis=Z Is_Positive=true InitPos=13.62205deg Angular_Velocity=3900rpm Objects=Band
  Moving1: Moving Objects=[InnerRegion, Rotor, Mag_0..Mag_11]
boundaries and excitations:
  PhA_0: Coil Terminal Objects=CoilTerm_0 Conductor_number=24 Winding=PhaseA Point_out_of_terminal=false
  PhB_1: Coil Terminal Objects=CoilTerm_1 Conductor_number=24 Winding=PhaseB Point_out_of_terminal=false
  PhC_2: Coil Terminal Objects=CoilTerm_2 Conductor_number=24 Winding=PhaseC Point_out_of_terminal=false
  PhA_3: Coil Terminal Objects=CoilTerm_3 Conductor_number=24 Winding=PhaseA Point_out_of_terminal=false
  PhB_4: Coil Terminal Objects=CoilTerm_4 Conductor_number=24 Winding=PhaseB Point_out_of_terminal=false
  PhA_5: Coil Terminal Objects=CoilTerm_5 Conductor_number=24 Winding=PhaseA Point_out_of_terminal=false
  PhB_6: Coil Terminal Objects=CoilTerm_6 Conductor_number=24 Winding=PhaseB Point_out_of_terminal=false
  PhC_7: Coil Terminal Objects=CoilTerm_7 Conductor_number=24 Winding=PhaseC Point_out_of_terminal=false
  PhA_8: Coil Terminal Objects=CoilTerm_8 Conductor_number=24 Winding=PhaseA Point_out_of_terminal=false
  PhC_9: Coil Terminal Objects=CoilTerm_9 Conductor_number=24 Winding=PhaseC Point_out_of_terminal=false
  PhA_10: Coil Terminal Objects=CoilTerm_10 Conductor_number=24 Winding=PhaseA Point_out_of_terminal=false
  PhB_11: Coil Terminal Objects=CoilTerm_11 Conductor_number=24 Winding=PhaseB Point_out_of_terminal=false
  PhC_12: Coil Terminal Objects=CoilTerm_12 Conductor_number=24 Winding=PhaseC Point_out_of_terminal=false
  PhB_13: Coil Terminal Objects=CoilTerm_13 Conductor_number=24 Winding=PhaseB Point_out_of_terminal=false
  PhC_14: Coil Terminal Objects=CoilTerm_14 Conductor_number=24 Winding=PhaseC Point_out_of_terminal=false
  PhaseA: Winding Group Type=External IsSolid=false Current=0A ParallelBranchesNum=1
  PhaseB: Winding Group Type=External IsSolid=false Current=0A ParallelBranchesNum=1
  PhaseC: Winding Group Type=External IsSolid=false Current=0A ParallelBranchesNum=1
  external circuit: "* Design: MaxCir1\"
mesh:
  Length_Coil: LengthBased RefineInside Objects=[Coil_0..Coil_14] MaxLength=8mm
  SurfPriority1: SurfaceRepPriority Objects=[Coil_0..Coil_14] SurfaceRepPriority=0
  SurfApprox_Coil: SurfApproxBased Objects=[Coil_0..Coil_14] CurvedSurfaceApproxChoice=ManualSettings NormalDev=30deg
  Length_Mag: LengthBased RefineInside Objects=[Mag_0..Mag_11] MaxLength=8mm
  Length_Main: LengthBased RefineInside Objects=[Stator, Rotor] MaxLength=12mm
  Length_Band: LengthBased RefineInside Objects=[Band, OuterRegion] MaxLength=6mm
  Length_Region: LengthBased RefineInside Objects=[InnerRegion, StatorRegion] MaxLength=12mm
  CylindricalGap1: CylindricalGap Objects=Band BandMappingAngle=3deg MovingSideLayers=1 StaticSideLayers=1 Objects=Band
  initial mesh: MeshMethod=AnsoftTAU
setups:
  Setup1: Transient NonlinearSolverResidual=0.005 ScalarPotential="Second Order" StopTime=0.025641026s TimeStep=3e-05s OutputPerObjectCoreLoss
output variables:
  pos = (Moving1.Position -13.6221 * PI/180) * 6 + PI
  cos0 = cos(pos)
  cos1 = cos(pos-2*PI/3)
  cos2 = cos(pos-4*PI/3)
  sin0 = -sin(pos)
  sin1 = -sin(pos-2*PI/3)
  sin2 = -sin(pos-4*PI/3)
  Lad = L(PhaseA,PhaseA)*cos0 + L(PhaseA,PhaseB)*cos1 + L(PhaseA,PhaseC)*cos2
  Laq = L(PhaseA,PhaseA)*sin0 + L(PhaseA,PhaseB)*sin1 + L(PhaseA,PhaseC)*sin2
  Lbd = L(PhaseB,PhaseA)*cos0 + L(PhaseB,PhaseB)*cos1 + L(PhaseB,PhaseC)*cos2
  Lbq = L(PhaseB,PhaseA)*sin0 + L(PhaseB,PhaseB)*sin1 + L(PhaseB,PhaseC)*sin2
  Lcd = L(PhaseC,PhaseA)*cos0 + L(PhaseC,PhaseB)*cos1 + L(PhaseC,PhaseC)*cos2
  Lcq = L(PhaseC,PhaseA)*sin0 + L(PhaseC,PhaseB)*sin1 + L(PhaseC,PhaseC)*sin2
  L_d = (Lad*cos0 + Lbd*cos1 + Lcd*cos2) * 2/3
  L_q = (Laq*sin0 + Lbq*sin1 + Lcq*sin2) * 2/3
  Flux_d = (FluxLinkage(PhaseA)*cos0+FluxLinkage(PhaseB)*cos1+FluxLinkage(PhaseC)*cos2)*2/3
  Flux_q = (FluxLinkage(PhaseA)*sin0+FluxLinkage(PhaseB)*sin1+FluxLinkage(PhaseC)*sin2)*2/3
  I_d = (Current(PhaseA)*cos0 + Current(PhaseB)*cos1 + Current(PhaseC)*cos2)*2/3
  I_q = (Current(PhaseA)*sin0 + Current(PhaseB)*sin1 + Current(PhaseC)*sin2)*2/3
  Irms = sqrt(I_d^2+I_q^2)/sqrt(2.0)
  Pcu = 3*Irms^2*0
reports:
  Stator Currents: Current(PhaseA), Current(PhaseB), Current(PhaseC) vs Time on Setup1 : Transient
  Torque: Moving1.Torque vs Time on Setup1 : Transient
  L_dq: L_d, L_q vs Time on Setup1 : Transient
  Flux_dq: Flux_d, Flux_q vs Time on Setup1 : Transient
  I_dq: I_d, I_q vs Time on Setup1 : Transient
